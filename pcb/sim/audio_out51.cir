* Audio output stage U4 (TL072, TI 1989 macromodel): codec -> 100R (codec Zout) -> 10k -> inverting, Rf || Cf, 100R -> 100k load
.include models/tl072.mod
.param RF=39k CF=100p
VCC vp 0 11.7
VEE vn 0 -11.7
VIN src 0 DC 0 AC 1 SIN(0 1.4142 1k)
RZ src cod 100
RIN cod inv 10k
RF inv out {RF}
CF inv out {CF}
XU 0 inv vp vn out TL072
RS out jack 100
RL jack 0 100k
.control
set noaskquit
alter RF = 49.9k
alter CF = 47p
echo "=== RF 49.9k CF 47p"
dc VIN -3 3 0.005
meas dc vmax max v(jack)
ac dec 50 10 1meg
meas ac g1k find vdb(jack) at=1k
meas ac g20k find vdb(jack) at=20k
let g3 = g1k - 3
meas ac f3db when vdb(jack)=g3 fall=1
meas ac pk max vdb(jack) from=1k to=1meg
tran 2u 5m
fourier 1k v(jack)
alter RF = 51k
alter CF = 47p
echo "=== RF 51k CF 47p"
dc VIN -3 3 0.005
meas dc vmax max v(jack)
ac dec 50 10 1meg
meas ac g1k find vdb(jack) at=1k
meas ac g20k find vdb(jack) at=20k
let g3 = g1k - 3
meas ac f3db when vdb(jack)=g3 fall=1
meas ac pk max vdb(jack) from=1k to=1meg
tran 2u 5m
fourier 1k v(jack)
alter RF = 51k
alter CF = 68p
echo "=== RF 51k CF 68p"
dc VIN -3 3 0.005
meas dc vmax max v(jack)
ac dec 50 10 1meg
meas ac g1k find vdb(jack) at=1k
meas ac g20k find vdb(jack) at=20k
let g3 = g1k - 3
meas ac f3db when vdb(jack)=g3 fall=1
meas ac pk max vdb(jack) from=1k to=1meg
tran 2u 5m
fourier 1k v(jack)
.endc
.end
